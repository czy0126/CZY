* v3 check NEG: REG reaches UVLO before any VD>1.5 V.  Unsupported power-up order.
* Expectation: PRE stays 0, violation flag latches, no gate on either channel.
.include ../../models/sr_timing_v3.lib
Vreg reg 0 PWL(0 0 0.1u 0 0.2u 11 20u 11)
Vd1 d1 0 PWL(0 0 1u 0 1.01u 4 4u 4 4.01u -.6 4.8u -.6 4.81u .1 9u .1 9.01u 4 20u 4)
Vd2 d2 0 PWL(0 0 1u 0 1.01u 4 20u 4)
Xsr d1 d2 g1 g2 reg 0 pre SR_TIMING
.tran 0 12u 0 1n
.save V(d1) V(d2) V(g1) V(g2) V(reg) V(pre) V(xsr:viol) V(xsr:q1) V(xsr:q2)
.meas tran gate1_max MAX V(g1)
.meas tran gate2_max MAX V(g2)
.meas tran pre_final FIND V(pre) AT=11.9u
.meas tran viol_final FIND V(xsr:viol) AT=11.9u
.meas tran q1_max MAX V(xsr:q1)
.meas tran q2_max MAX V(xsr:q2)
.end
