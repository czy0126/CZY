* Forward ID-VDS, VGS = 10 / 4.5 / 3.0 V   (Vin = 50 A point for Rds(on))
.include ../../models/sr_device_v3.lib
Vd d 0 0
Vg g 0 {VG}
X1 d g 0 SR_DEVICE
.step param VG list 10 4.5 3.0
.dc Vd 0 1.2 0.001
.options plotwinsize=0
.meas dc RDS50 FIND V(d)/50 WHEN I(Vd)=-50
.meas dc ID1V FIND -I(Vd) AT 1.0
.meas dc ID02 FIND -I(Vd) AT 0.2
.end
