* Adversarial check: temperature scaling of Rds(on) in sr_device_v3.lib (TJ parameter).
.include ../../models/sr_device_v3.lib
Vd d 0 0
Vg g 0 10
X1 d g 0 SR_DEVICE TJ={TJA}
.step param TJA list 25 125 175
.dc Vd 0 0.2 0.001
.options plotwinsize=0
.meas dc ron FIND V(d)/-I(Vd) AT=0.1
.end
