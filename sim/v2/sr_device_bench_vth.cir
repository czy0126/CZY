* Vth bench: VDS=VGS, ID=250 uA (datasheet VGS(th) test condition)
.include ../../models/sr_device_v3.lib
Vg g 0 0
Vs d g 0
X1 d g 0 SR_DEVICE
.dc Vg 0 3 0.002
.options plotwinsize=0
.meas dc vth WHEN -I(Vs)=250u
.meas dc id15 FIND -I(Vs) AT=1.5
.meas dc id20 FIND -I(Vs) AT=2.0
.meas dc id23 FIND -I(Vs) AT=2.3
.end
