* Third quadrant: body diode, VGS = 0
.include ../../models/sr_device_v3.lib
Vd d 0 0
Vg g 0 0
X1 d g 0 SR_DEVICE
.dc Vd 0 -1.5 -0.001
.options plotwinsize=0
.meas dc VSD50 FIND -V(d) WHEN I(Vd)=50
.meas dc VSD10 FIND -V(d) WHEN I(Vd)=10
.meas dc VSD100 FIND -V(d) WHEN I(Vd)=100
.meas dc IDM1V FIND I(Vd) AT -1.0
.end
