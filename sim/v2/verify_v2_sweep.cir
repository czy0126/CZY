* Forced sinusoidal current SR commutation bench, NOT full LLC/device model
.include ../../models/sr_timing_v2.lib
.param PGD=0 TDELAY=23n
Vclamp bus 0 4
Vreg reg 0 PWL(0 0 1u 0 2u 11 30u 11)
Rinit1 bus d1 10k
Rinit2 bus d2 10k
Bload1 d1 0 I=if(time>3u,40*sin(2*pi*200k*(time-3u)),0)
Bload2 d2 0 I=if(time>3u,-40*sin(2*pi*200k*(time-3u)),0)
Dcl1 d1 bus CLAMP
Dcl2 d2 bus CLAMP
.model CLAMP D(Ron=.02 Roff=1G Vfwd=.2)
Vsa d1 da 0
Vsb d2 db 0
Sa da 0 ga 0 MOSCHANNEL
Sb db 0 gb 0 MOSCHANNEL
Da 0 da BODY
Db 0 db BODY
.model MOSCHANNEL SW(Ron=1.5m Roff=1G Vt=2 Vh=-.2)
.model BODY D(Ron=1.5m Roff=1G Vfwd=.65)
Cda da 0 2n
Cdb db 0 2n
Xsr d1 d2 ga gb reg 0 pre SR_TIMING PGD={PGD} TOFF={TDELAY}
.step param PGD list 0 1
.step param TDELAY list 5.5n 23n 40n
.tran 0 20u 0 2n
.save V(d1) V(d2) V(ga) V(gb) V(pre) I(Vsa) I(Vsb) I(Sa) I(Sb)
.meas tran REVERSE_PEAK MAX (-I(Sa)) FROM 10u TO 20u
.meas tran FORWARD_PEAK MIN (-I(Sa)) FROM 10u TO 20u
.meas tran GATE_OVERLAP MAX min(V(ga),V(gb)) FROM 10u TO 20u
.end
