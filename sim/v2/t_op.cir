* op test (first line is the title in LTspice)
.include ../../models/sr_device_v3.lib
Vd d 0 0.0449
Vg g 0 10
X1 d g 0 SR_DEVICE
.op
.meas op ivd FIND I(Vd)
.meas op idrain FIND -I(Vd)
.end
