* CSS5x (Css=50n) single-parameter startup-surge test: everything else identical.
* Driver-integrated variant of startup_ct.cir: UCC27282 replaces Dbt/Bgh/Bgl.
* The original deck is kept unchanged as the behavioural reference.
* Task 2 step 1 (2026-10-31): replace the instantaneous abs(I(Lr)) OC proxy
* with a real current transformer.  Same REG sequencing and power stage as
* startup_seq_long.cir; ONLY the OC sensing chain changed.
* Numerical result, not hardware validation.
.include ../../models/ucc25600_legacy_behaviour.lib
.include ../../models/sr_timing_v2.lib
.include ../../models/ucc27282_behaviour.lib
.param PGD=1
.param VIN=48 RL=20m LP=10u LR_TOTAL=.92u CR_TOTAL=620n
.param FS=1/(2*(6n/(2.5/976)+150n)) TS=1/FS DT=149n
Vbus vin0 0 {VIN}
Rin vin0 vin 1m
Cin vin 0 20u Rser=5m
Vaux aux 0 PWL(0 0 2u 12)
Xctl dt rt oc ss gd2 0 aux gd1 R184_UCC25600
Rdt dt 0 5.36k
Rrt rt 0 976
Css ss 0 50n
Rss_dc ss 0 1G
* ---- Current transformer (1 turn : 100 turns) ------------------------------
* Independent of the centre-tapped power transformer: it is inserted in
* series with the resonant tank (Lct1 between Cr and Lr).
* Model: coupled inductors + Schottky bridge + burden + RC + divider.
* 1 turn Lm = 2 uH  =>  100 turns L = 20 mH; K = 0.9999 (0.01% leakage).
* Secondary loading reflects Rbur/N^2 = 10 ohm / 1e4 = 1 mohm into the
* tank, so the series insertion does not change the power stage.
* IDEAL-CT SINUSOIDAL ESTIMATE (ignores magnetising and rectifier error):
*   VOC ~= Ipri_peak/100 * 10 * (2/pi) * 24/35 ~= 0.04365 * Ipri_peak
* so 1 V at the OC pin corresponds to about 22.9 A SINUSOIDAL PEAK, not the
* 20 A claimed by the original note.  The original "2 V minus two Schottky
* drops = 1.3 V" is invalid for a bridge-loaded CT: the diode drops mainly
* raise the secondary voltage required, and the actual error must be solved
* from magnetising current, core and rectifier network.  This estimate does
* not cover start-up/fault transients.
* Filter Rf*Cf = 1k * 47n = 47 us (~9.4 switching periods at 200 kHz).
* The secondary is tied to the primary ground through Vctg only so that
* the model has a reference; this makes no isolation claim.
Lct1 nr nct 2u
Lct2 cs1 cs2 20m
Kct Lct1 Lct2 0.9999
D1 cs1 ocd DSCH
D2 cs2 ocd DSCH
D3 ocm cs1 DSCH
D4 ocm cs2 DSCH
.model DSCH D(Is=2n Rs=.3 N=1.2 Cjo=20p)
Vctg ocm 0 0
Rbur ocd ocm 10
Rf ocd oc1 1k
Cf oc1 ocm 47n
Rd1 oc1 oc 10k
Rd2 oc ocm 24k
Coc oc ocm 10n
* Real UCC27282 half-bridge driver (behavioural model).  The integrated
* bootstrap diode replaces Dbt; HI/LI are driven by the controller GD1/GD2.
* EN is tied to VDD, so the datasheet 18 us enable delay is modelled: the
* first gate pulse is delayed to ~18.3 us.  This is a real sequencing effect.
Cbt hb sw 220n Rser=.05
Xdrv aux hb sw lo ho gd1 gd2 aux 0 UCC27282
Rgh ho gh 3.2
Rgl lo gl 3.2
RgsH gh sw 10k
RgsL gl 0 10k
SH vin sw gh sw PRI_SW
DH sw vin BODY_P
Cgh gh sw 4n
Cdh vin sw 560p
SL sw 0 gl 0 PRI_SW
DL 0 sw BODY_P
Cgl gl 0 4n
Cdl sw 0 560p
.model PRI_SW SW(Ron=8m Roff=100Meg Vt=2.5 Vh=-.2)
.model BODY_P D(Ron=8m Roff=1G Vfwd=.7)
Cr sw nr {CR_TOTAL} Rser=3m
Lr nct p1 {LR_TOTAL} Rser=5m
Lp1 p1 p2 {LP} Rser=3m
Lp2 p2 p3 {LP} Rser=3m
Lp3 p3 p4 {LP} Rser=3m
Lp4 p4 0 {LP} Rser=3m
Lsa1 out a1 {LP/9} Rser=0.15m
Lsb1 b1 out {LP/9} Rser=0.15m
Lsa2 out a2 {LP/9} Rser=0.15m
Lsb2 b2 out {LP/9} Rser=0.15m
Lsa3 out a3 {LP/9} Rser=0.15m
Lsb3 b3 out {LP/9} Rser=0.15m
Lsa4 out a4 {LP/9} Rser=0.15m
Lsb4 b4 out {LP/9} Rser=0.15m
K1 Lp1 Lsa1 Lsb1 .999
K2 Lp2 Lsa2 Lsb2 .999
K3 Lp3 Lsa3 Lsb3 .999
K4 Lp4 Lsa4 Lsb4 .999
.model SR_SW SW(Ron=1.5m Roff=100Meg Vt=2 Vh=-.2)
.model BODY_S D(Ron=1.5m Roff=1G Vfwd=.65)
* REG held at 0 until 130 us, then ramps 11 V by 150 us.
Vreg reg sgnd PWL(0 0 130u 0 150u 11 1m 11)
VSa1 a1 da1 0
Sa1 da1 sgnd ga1 sgnd SR_SW
Da1 sgnd da1 BODY_S
Cda1 da1 sgnd 2n
VSb1 b1 db1 0
Sb1 db1 sgnd gb1 sgnd SR_SW
Db1 sgnd db1 BODY_S
Cdb1 db1 sgnd 2n
Xsr1 a1 b1 ga1 gb1 reg sgnd pre1 SR_TIMING PGD={PGD}
VSa2 a2 da2 0
Sa2 da2 sgnd ga2 sgnd SR_SW
Da2 sgnd da2 BODY_S
Cda2 da2 sgnd 2n
VSb2 b2 db2 0
Sb2 db2 sgnd gb2 sgnd SR_SW
Db2 sgnd db2 BODY_S
Cdb2 db2 sgnd 2n
Xsr2 a2 b2 ga2 gb2 reg sgnd pre2 SR_TIMING PGD={PGD}
VSa3 a3 da3 0
Sa3 da3 sgnd ga3 sgnd SR_SW
Da3 sgnd da3 BODY_S
Cda3 da3 sgnd 2n
VSb3 b3 db3 0
Sb3 db3 sgnd gb3 sgnd SR_SW
Db3 sgnd db3 BODY_S
Cdb3 db3 sgnd 2n
Xsr3 a3 b3 ga3 gb3 reg sgnd pre3 SR_TIMING PGD={PGD}
VSa4 a4 da4 0
Sa4 da4 sgnd ga4 sgnd SR_SW
Da4 sgnd da4 BODY_S
Cda4 da4 sgnd 2n
VSb4 b4 db4 0
Sb4 db4 sgnd gb4 sgnd SR_SW
Db4 sgnd db4 BODY_S
Cdb4 db4 sgnd 2n
Xsr4 a4 b4 ga4 gb4 reg sgnd pre4 SR_TIMING PGD={PGD}
Cout out sgnd 4m Rser=0.2m
Rload out sgnd {RL}
Vref sgnd 0 0
.options plotwinsize=0 method=gear

.tran 0 1.5m 0 30n uic
.save V(ho) V(lo) V(out) V(sgnd) V(sw) V(gh) V(gl) V(hb) V(gd1) V(gd2) V(ss) V(reg) V(pre1)
+ V(a1) V(b1) V(ga1) V(gb1) I(VSa1) I(VSb1) I(Sa1) I(Sb1) I(Lr) I(Vbus)
+ V(oc) V(oc1) V(ocd) V(cs1) I(Lct1) I(Lct2) I(Rbur)
.meas tran OC_MAX MAX V(oc) FROM 0 TO 1.5m
.meas tran OC_1M FIND V(oc) AT=1m
.meas tran OCD_MAX MAX V(ocd) FROM 0 TO 1.5m
.meas tran ICT_PK MAX abs(I(Lct2)) FROM 0 TO 1.5m
.meas tran PRE_AT_1M FIND V(pre1,sgnd) AT=1m
.meas tran VOUT_AVG AVG V(out,sgnd) FROM 1.2m TO 1.5m
.meas tran VOUT_MAX MAX V(out,sgnd) FROM 0 TO 1.5m
.meas tran IPRI_PK MAX abs(I(Lr))
.meas tran SR_REVERSE MAX (-I(Sa1)) FROM 1.2m TO 1.5m
.meas tran SR_GATE_MAX MAX V(ga1,sgnd)
.meas tran SR_GATE_AT_1M FIND V(ga1,sgnd) AT=1m
.end
