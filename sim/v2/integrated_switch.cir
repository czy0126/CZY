* DCX V1 - corrected power-only baseline, NOT a hardware control model
* Ideal unidirectional SR equivalents cannot validate reverse current or SR timing.
.include ../../models/ucc25600_legacy_behaviour.lib
.include ../../models/sr_timing_v2.lib
.param PGD=0
.param VIN=48 RL=20m LP=10u LR_TOTAL=.92u CR_TOTAL=620n
.param FS=1/(2*(6n/(2.5/976)+150n)) TS=1/FS DT=149n
Vbus vin0 0 {VIN}
Rin vin0 vin 1m
Cin vin 0 20u Rser=5m
* Physical bootstrap and finite gate impedance; driver logical surrogate, not TI model
Vaux aux 0 PWL(0 0 2u 12)
Xctl dt rt oc ss gd2 0 aux gd1 R184_UCC25600
Rdt dt 0 5.36k
Rrt rt 0 976
Css ss 0 10n
Rss_dc ss 0 1G
Voc oc 0 0
Dbt aux hb DBOOT
Cbt hb sw 220n Rser=.05
.model DBOOT D(Is=10n Rs=.5 N=1.2)
Bgh gh0 sw V=if(V(hb,sw)>5.5,if(delay(V(gd1),20n)>2,if(V(gd2)<2,V(hb,sw),0),0),0)
Bgl gl0 0 V=if(V(aux)>5.5,if(delay(V(gd2),20n)>2,if(V(gd1)<2,V(aux),0),0),0)
Rgh gh0 gh 3.2
Rgl gl0 gl 3.2
RgsH gh sw 10k
RgsL gl 0 10k
SH vin sw gh sw PRI_SW
DH sw vin BODY_P
Cgh gh sw 4n
Cdh vin sw 560p
SL sw 0 gl 0 PRI_SW
DL 0 sw BODY_P
Cgl gl 0 4n
Cdl sw 0 560p
.model PRI_SW SW(Ron=8m Roff=100Meg Vt=2.5 Vh=-.2)
.model BODY_P D(Ron=8m Roff=1G Vfwd=.7)
Cr sw nr {CR_TOTAL} Rser=3m
Lr nr p1 {LR_TOTAL} Rser=5m
Lp1 p1 p2 {LP} Rser=3m
Lp2 p2 p3 {LP} Rser=3m
Lp3 p3 p4 {LP} Rser=3m
Lp4 p4 0 {LP} Rser=3m
Lsa1 out a1 {LP/9} Rser=0.15m
Lsb1 b1 out {LP/9} Rser=0.15m
Lsa2 out a2 {LP/9} Rser=0.15m
Lsb2 b2 out {LP/9} Rser=0.15m
Lsa3 out a3 {LP/9} Rser=0.15m
Lsb3 b3 out {LP/9} Rser=0.15m
Lsa4 out a4 {LP/9} Rser=0.15m
Lsb4 b4 out {LP/9} Rser=0.15m
K1 Lp1 Lsa1 Lsb1 .999
K2 Lp2 Lsa2 Lsb2 .999
K3 Lp3 Lsa3 Lsb3 .999
K4 Lp4 Lsa4 Lsb4 .999
* Bilateral approximate MOS channels; body diode, gate and output capacitances included
* Actual selected-device model and measured parasitics are still required.
.model SR_SW SW(Ron=1.5m Roff=100Meg Vt=2 Vh=-.2)
.model BODY_S D(Ron=1.5m Roff=1G Vfwd=.65)
Vreg reg sgnd PWL(0 0 80u 0 100u 11 1m 11)
VSa1 a1 da1 0
Sa1 da1 sgnd ga1 sgnd SR_SW
Da1 sgnd da1 BODY_S
Cda1 da1 sgnd 2n
VSb1 b1 db1 0
Sb1 db1 sgnd gb1 sgnd SR_SW
Db1 sgnd db1 BODY_S
Cdb1 db1 sgnd 2n
Xsr1 a1 b1 ga1 gb1 reg sgnd pre1 SR_TIMING PGD={PGD}
VSa2 a2 da2 0
Sa2 da2 sgnd ga2 sgnd SR_SW
Da2 sgnd da2 BODY_S
Cda2 da2 sgnd 2n
VSb2 b2 db2 0
Sb2 db2 sgnd gb2 sgnd SR_SW
Db2 sgnd db2 BODY_S
Cdb2 db2 sgnd 2n
Xsr2 a2 b2 ga2 gb2 reg sgnd pre2 SR_TIMING PGD={PGD}
VSa3 a3 da3 0
Sa3 da3 sgnd ga3 sgnd SR_SW
Da3 sgnd da3 BODY_S
Cda3 da3 sgnd 2n
VSb3 b3 db3 0
Sb3 db3 sgnd gb3 sgnd SR_SW
Db3 sgnd db3 BODY_S
Cdb3 db3 sgnd 2n
Xsr3 a3 b3 ga3 gb3 reg sgnd pre3 SR_TIMING PGD={PGD}
VSa4 a4 da4 0
Sa4 da4 sgnd ga4 sgnd SR_SW
Da4 sgnd da4 BODY_S
Cda4 da4 sgnd 2n
VSb4 b4 db4 0
Sb4 db4 sgnd gb4 sgnd SR_SW
Db4 sgnd db4 BODY_S
Cdb4 db4 sgnd 2n
Xsr4 a4 b4 ga4 gb4 reg sgnd pre4 SR_TIMING PGD={PGD}
Cout out sgnd 4m Rser=0.2m
Rload out sgnd {RL}
Rref sgnd 0 1G
.options plotwinsize=0 method=gear
.tran 0 150u 0 10n
.save V(out) V(sgnd) V(sw) V(gh) V(gl) V(hb) V(gd1) V(gd2) V(ss) V(reg) V(pre1)
+ V(a1) V(b1) V(ga1) V(gb1) I(VSa1) I(VSb1) I(Lr) I(Vbus)
.meas tran VOUT_AVG AVG V(out,sgnd) FROM 120u TO 150u
.meas tran IPRI_PK MAX abs(I(Lr))
.meas tran SR_REVERSE MAX I(VSa1) FROM 120u TO 150u
.meas tran SR_GATE_MAX MAX V(ga1,sgnd)
.meas tran PRE_END FIND V(pre1,sgnd) AT=140u
.end
