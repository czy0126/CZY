* ============================================================================
* Gate-drive calibration A: timing-model driver into a lumped gate capacitor.
* The driver is byte-identical to models/sr_timing_v3.lib:
*   Bdrv  target 0 -> 10.9 V at 1 us, back to 0 at 2 us
*   Bdrive = limit((V(G)-V(drv))/R, -1.5, 4)  with R = 8.7 ohm source / 3.1 ohm sink
*     (6.5/0.9 ohm internal + 2.2 ohm external gate resistor, per the design notes)
* CG is the "6.7 nF gate surrogate" of sr_timing_v3.lib.  With no device
* attached this reproduces the datasheet test load (6.8 nF) alone.
* Purpose: separate the driver's own edge times from the device's gate charge.
* CG=0 is an ideal (zero-load) limit case: the edge times there are numerical,
* not physical, and the TRIG/TARG measurements may fail; that failure is
* expected and is not a deck error.
* Numerical result, not hardware validation.
* ============================================================================
Bdrv drv 0 V=if(time>2u,0,if(time>1u,10.9,0))
Bdrive G 0 I=limit((V(G)-V(drv))/if(V(drv)>V(G),8.7,3.1),-1.5,4)
Rgs G 0 10k
Cgate G 0 {CG}
.tran 0 3u 0 20p
.options plotwinsize=0
.step param CG list 0 6.7n
.meas tran vg_peak MAX V(G) FROM 0 TO 2u
.meas tran tr_10_90 TRIG V(G)=1.089 RISE=1 TARG V(G)=9.801 RISE=1
.meas tran tf_90_10 TRIG V(G)=9.801 FALL=1 TARG V(G)=1.089 FALL=1
.end
