* DCX V1 - corrected power-only baseline, NOT a hardware control model
* Ideal unidirectional SR equivalents cannot validate reverse current or SR timing.
.include ../../models/ucc25600_legacy_behaviour.lib
.include ../../models/sr_timing_v2.lib
.param PGD=0
.param VIN=48 RL=20m LP=10u LR_TOTAL=1u CR_TOTAL=620n
.param FS=1/(2*(6n/(2.5/976)+150n)) TS=1/FS DT=149n
Vbus vin0 0 {VIN}
Rin vin0 vin 1m
Cin vin 0 20u Rser=5m
* Physical bootstrap and finite gate impedance; driver logical surrogate, not TI model
Vaux aux 0 PWL(0 0 2u 12)
Xctl dt rt oc ss gd2 0 aux gd1 R184_UCC25600
Rdt dt 0 5.36k
Rrt rt 0 976
Css ss 0 10n
Rss_dc ss 0 1G
Voc oc 0 0
Dbt aux hb DBOOT
Cbt hb sw 220n Rser=.05
.model DBOOT D(Is=10n Rs=.5 N=1.2)
Bgh gh0 sw V=if(V(hb,sw)>5.5,if(delay(V(gd1),20n)>2,if(V(gd2)<2,V(hb,sw),0),0),0)
Bgl gl0 0 V=if(V(aux)>5.5,if(delay(V(gd2),20n)>2,if(V(gd1)<2,V(aux),0),0),0)
Rgh gh0 gh 3.2
Rgl gl0 gl 3.2
RgsH gh sw 10k
RgsL gl 0 10k
MH vin gh sw sw PRI_APPROX
ML sw gl 0 0 PRI_APPROX
.model PRI_APPROX VDMOS(Vto=2.5 Kp=100 Rd=3.5m Rs=3.5m Cgs=4n Cgdmax=1n Cgdmin=50p Cjo=500p Is=1n Bv=100)
Cr sw nr {CR_TOTAL} Rser=3m
Lr nr p1 {LR_TOTAL} Rser=5m
Lp1 p1 p2 {LP} Rser=3m
Lp2 p2 p3 {LP} Rser=3m
Lp3 p3 p4 {LP} Rser=3m
Lp4 p4 0 {LP} Rser=3m
Lsa1 out a1 {LP/9} Rser=0.15m
Lsb1 b1 out {LP/9} Rser=0.15m
Lsa2 out a2 {LP/9} Rser=0.15m
Lsb2 b2 out {LP/9} Rser=0.15m
Lsa3 out a3 {LP/9} Rser=0.15m
Lsb3 b3 out {LP/9} Rser=0.15m
Lsa4 out a4 {LP/9} Rser=0.15m
Lsb4 b4 out {LP/9} Rser=0.15m
K1 Lp1 Lsa1 Lsb1 1
K2 Lp2 Lsa2 Lsb2 1
K3 Lp3 Lsa3 Lsb3 1
K4 Lp4 Lsa4 Lsb4 1
* Bilateral approximate MOS channels; body diode, gate and output capacitances included
* Actual selected-device model and measured parasitics are still required.
.model SR_APPROX VDMOS(Vto=2 Kp=200 Rd=.4m Rs=.4m Cgs=10p Cgdmax=200p Cgdmin=50p Cjo=2n Is=1u Bv=40)
Vreg reg sgnd PWL(0 0 80u 0 100u 11 1m 11)
Ma1 a1 ga1 sgnd sgnd SR_APPROX
Mb1 b1 gb1 sgnd sgnd SR_APPROX
Xsr1 a1 b1 ga1 gb1 reg sgnd pre1 SR_TIMING PGD={PGD}
Ma2 a2 ga2 sgnd sgnd SR_APPROX
Mb2 b2 gb2 sgnd sgnd SR_APPROX
Xsr2 a2 b2 ga2 gb2 reg sgnd pre2 SR_TIMING PGD={PGD}
Ma3 a3 ga3 sgnd sgnd SR_APPROX
Mb3 b3 gb3 sgnd sgnd SR_APPROX
Xsr3 a3 b3 ga3 gb3 reg sgnd pre3 SR_TIMING PGD={PGD}
Ma4 a4 ga4 sgnd sgnd SR_APPROX
Mb4 b4 gb4 sgnd sgnd SR_APPROX
Xsr4 a4 b4 ga4 gb4 reg sgnd pre4 SR_TIMING PGD={PGD}
Cout out sgnd 4m Rser=0.2m
Rload out sgnd {RL}
Rref sgnd 0 1G
.options plotwinsize=0
.tran 0 350u 0 10n
.save V(out) V(sgnd) V(sw) V(gh) V(gl) V(hb) V(gd1) V(gd2) V(ss) V(reg) V(pre1)
+ V(a1) V(b1) V(ga1) V(gb1) I(Ma1) I(Mb1) I(Lr) I(Vbus)
.meas tran VOUT_AVG AVG V(out,sgnd) FROM 300u TO 350u
.meas tran IPRI_PK MAX abs(I(Lr))
.meas tran SR_REVERSE MAX I(Ma1) FROM 300u TO 350u
.meas tran SR_GATE_MAX MAX V(ga1,sgnd)
.meas tran PRE_END FIND V(pre1,sgnd) AT=340u
.end
