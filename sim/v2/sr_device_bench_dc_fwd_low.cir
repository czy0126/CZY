* Forward ID-VDS at VGS = 2.5 V (channel near threshold)
.include ../../models/sr_device_v3.lib
Vd d 0 0
Vg g 0 2.5
X1 d g 0 SR_DEVICE
.dc Vd 0 1.2 0.001
.options plotwinsize=0
.meas dc ID02 FIND -I(Vd) AT 0.2
.meas dc ID05 FIND -I(Vd) AT 0.5
.meas dc ID10 FIND -I(Vd) AT 1.0
.meas dc IDMAX MAX -I(Vd)
.end
