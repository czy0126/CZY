* Adversarial check: third-quadrant conduction with the CHANNEL ON (VGS=10/4.5).
* The project bench only tested VGS=0 (body diode); the SR on-state is the channel.
.include ../../models/sr_device_v3.lib
Vd d 0 0
Vg g 0 {VG}
X1 d g 0 SR_DEVICE
.step param VG list 10 4.5
.dc Vd 0 -0.3 -0.001
.options plotwinsize=0
.meas dc rev100 FIND I(Vd) AT=-0.1
.meas dc revs50 FIND -V(d) WHEN I(Vd)=50
.meas dc revpeak MIN V(d)
.end
