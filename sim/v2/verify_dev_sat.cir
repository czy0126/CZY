* Adversarial check: saturated-region current of the stand-in at 40 V / VGS=10 V.
.include ../../models/sr_device_v3.lib
Vd d 0 0
Vg g 0 10
X1 d g 0 SR_DEVICE
.dc Vd 0 40 0.1
.options plotwinsize=0
.meas dc id40 FIND -I(Vd) AT=40
.meas dc id1 FIND -I(Vd) AT=1
.end
