* function test
B1 a 0 V=log(exp(1))
B2 b 0 V=log10(100)
B3 c 0 V=if(2>1, 3, 4)
B4 dd 0 V=min(5,2)
B5 e 0 V=abs(-2.5)
B6 f 0 V=exp(1)
R1 a 0 1k
R2 b 0 1k
R3 c 0 1k
R4 dd 0 1k
R5 e 0 1k
R6 f 0 1k
.tran 1u 2u
.meas tran va FIND V(a) AT 1u
.meas tran vb FIND V(b) AT 1u
.meas tran vc FIND V(c) AT 1u
.meas tran vd FIND V(dd) AT 1u
.meas tran ve FIND V(e) AT 1u
.meas tran vf FIND V(f) AT 1u
.end
