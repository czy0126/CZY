* reverse recovery sweep over tt (forced di/dt, VR clamp 20V)
I1 a 0 PWL(0 10 100n 10 162.5n -15 400n -15)
Dc a c DC
Vc c 0 20
.model DC D(Is=1e-9 N=1 Cjo=0)
Vs a d 0
D1 0 d DB
.model DB D(Is=6e-12 N=1.05 tt={TT} Cjo=0)
.step param TT list 24n 26n 28n 30n 32n
.tran 0 400n 0 0.05n uic
.meas tran IRR MIN -I(Vs) FROM 100n TO 300n
.meas tran TZ WHEN -I(Vs)=0 FALL=1 TD=100n
.meas tran QRR INTEG -I(Vs) FROM 125n TO 300n
.meas tran TRET WHEN -I(Vs)=-0.05 RISE=1 TD=125n
.end
