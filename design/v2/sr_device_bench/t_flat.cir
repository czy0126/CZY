* flat copy of channel to debug Rds
Vd d 0 0.045
Vg g 0 10
Ld d di 0.3n
Ls 0 si 0.8n
Lg g gn 2.5n
Rg gn gi 1
Bkt kt 0 V=1+3.74740875m*(25-25)+9.04084303u*(25-25)**2+16.1532266n*(25-25)**3
Bvgs vgs 0 V=min(max(V(gi,si),-10),20)
Br r 0 V=V(kt)*(0.891492m+0.1*exp(-(V(vgs)-1.65)/0.303313)+1.41369m*exp(-(V(vgs)-1.65)/1.52911))
Bis isat 0 V=1/(1/(166.528*((0.08810546*log(1+exp((V(vgs)-1.976226)/0.08810546)))**3.606594))+1/1364.404)
Bch di si I=V(di,si)/(V(r)*(1+(abs(V(di,si))/(V(r)*V(isat)))**3)**(1.0/3))
Dbd si di DB
.model DB D(IS=6e-12 N=1.05 TT=27n CJO=0 RS=0)
.tran 0 5u 0 0.5u
.meas tran vgs FIND V(vgs) AT 4u
.meas tran rr FIND V(r) AT 4u
.meas tran iss FIND V(isat) AT 4u
.meas tran vds_i FIND V(di,si) AT 4u
.meas tran ich FIND I(Bch) AT 4u
.meas tran ivd FIND I(Vd) AT 4u

.meas tran vd FIND V(d) AT 4u
.meas tran vdi FIND V(di) AT 4u
.meas tran vsi FIND V(si) AT 4u
.meas tran ild FIND I(Ld) AT 4u
.meas tran ils FIND I(Ls) AT 4u
.meas tran idio FIND I(Dbd) AT 4u
.end
