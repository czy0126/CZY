* flat full model op test (title line)
Vd d 0 0.0449
Vg g 0 10
* ---- package ----------------------------------------------------------------
Ld d di 0.3n
Ls 0 si 0.8n
Lg g gn 2.5n
Rg gn gi 1
* ---- temperature factor for Rds(on), cubic fit, normalised to 25 C ----------
*  fit of datasheet diagram "Rds(on)=f(Tj)" normalised curve; max residual 0.002
Bkt kt 0 V=1+3.74740875m*(25-25)+9.04084303u*(25-25)**2+16.1532266n*(25-25)**3
* ---- clamped internal gate-source voltage (numerical guard) -----------------
Bvgs vgs 0 V=min(max(V(gi,si),-10),20)
* ---- channel ----------------------------------------------------------------
* Rds(Vgs) = R0 + R1*exp(-(Vgs-Vth)/T1) + R2*exp(-(Vgs-Vth)/T2), Vth=1.65 V
*   fitted to the datasheet Rds(on)-vs-Vgs curve at 25 C, ID=50 A
*   (3.0 V 2.65 mOhm, 4.5 V 1.15 mOhm, 10 V 0.893 mOhm; residuals < 2.5 %)
Br r 0 V=V(kt)*(0.891492m+0.1*exp(-(V(vgs)-1.65)/0.303313)+1.41369m*exp(-(V(vgs)-1.65)/1.52911))
* Isat(Vgs) = KP * [ s*ln(1+exp((Vgs-Vz)/s)) ]**p , smoothly limited to IMAX
*   fitted to the datasheet output-characteristic saturation points
*   (2.7 V 50 A, 3.0 V 160 A; 3.5 V/4.5 V points lie at the plot edge and are
*   used only as lower bounds).  Isat(2.5 V)=16 A, Isat(4.5 V)=1057 A.
Bis isat 0 V=1/(1/(166.528*((0.08810546*log(1+exp((V(vgs)-1.976226)/0.08810546)))**3.606594))+1/1364.404)
* Channel current with a smooth linear->saturation transition (n=3):
*   Ids = Vds / ( R * (1 + (|Vds|/(R*Isat))**3 )**(1/3) )
*   odd in Vds, so reverse (third-quadrant) conduction is not clamped.
Bch di si I=V(di,si)/(V(r)*(1+(abs(V(di,si))/(V(r)*V(isat)))**3)**(1.0/3))
* ---- body diode -------------------------------------------------------------
* IS/N chosen so Vsd = 0.807 V at 50 A (datasheet 0.80 V typ, 1.0 max).
* TT calibrated so the diode-only Qrr at IF=10 A, diF/dt=400 A/us is 97 nC.
* Cjo=0: device capacitance is modelled by Cds/Cgd above.
* NOTE: TJ is applied to Rds(on) only; the diode is evaluated at the deck
*       temperature (datasheet Vsd/Qrr/trr are 25 C values).
Dbd si di DB
.model DB D(IS=6e-12 N=1.05 TT=27n CJO=0 RS=0)
* ---- nonlinear capacitances (charge-defined) --------------------------------
* Cgd: piecewise-linear below VK, two-exponential above; fit of the Crss
*   diagram (0.5 V 783 pF ... 20 V 38.5 pF, 40 V 27 pF); Q(0..20 V)=5.36 nC
Bvgd vgd 0 V=abs(V(gi,di))
Bqgd qgd 0 V=if(V(vgd)<=8.52972, 735.774p*V(vgd)-56.7507p*V(vgd)*V(vgd)/2, 4.2116n+26.6784p*(V(vgd)-8.52972)+892.3p*(1-exp(-(V(vgd)-8.52972)/3.96525)))
Cgd gi di Q=1*if(V(gi,di)>=0, V(qgd), -V(qgd))
* Cds: fit of Coss-Crss diagram (0.5 V 6117 pF ... 40 V 833 pF)
*   Q(0..20 V)=67.6 nC ; Qoss = Qds+Qgd = 73.0 nC (datasheet 73 nC)
Bvds vds 0 V=abs(V(di,si))
Bqds qds 0 V=if(V(vds)<=10.0021, 6154.29p*V(vds)-297.645p*V(vds)*V(vds)/2, 46.666n+62.6184p*(V(vds)-10.0021)+9147.4p*(1-exp(-(V(vds)-10.0021)/5.29689))+69821p*(1-exp(-(V(vds)-10.0021)/50.3394)))
Cds di si Q=1*if(V(di,si)>=0, V(qds), -V(qds))
* Cgs: rises from 4.60 nF (Ciss-Crss) to 5.40 nF (datasheet gate-charge
*   post-plateau slope 0.163 V/nC minus Cgd(0)); soft transition, VS=2 V
Cgs gi si Q=1*if(V(gi,si)>0, 4.60n*V(gi,si)+0.80n*(V(gi,si)+2.0*(exp(-V(gi,si)/2.0)-1)), 4.60n*V(gi,si))
.op
.meas op vgsi FIND V(gi,si)
.meas op vr FIND V(r)
.meas op vis FIND V(isat)
.meas op iLd FIND I(Ld)
.meas op iLs FIND I(Ls)
.meas op ich FIND I(Bch)
.meas op vdd FIND V(di,si)
.meas op ivd FIND I(Vd)
.end
